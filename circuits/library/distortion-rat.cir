* ssp:title Op-amp hard-clip distortion (RAT)
* Values: the ProCo RAT schematic as commonly published, and the public circuit analysis at electrosmash.com/proco-rat.
* Input: CIN 22n, RB 2.2M to the bias (signal ground here), then RIN 1k and CRF 1n to ground, a radio-frequency filter, into the LM308 + input.
* Gain: a non-inverting stage. RV1 (100k log Distortion, wiper = output, one end open) with CFB 100p across it is the feedback. Two gain legs (560 + 4.7u, 47 + 2.2u) from the inverting input to ground set Rg. Gain 1 + RV1 / Rg is 62.7 dB at 1 kHz with Distortion at 1 (simulated; peak 64.2 dB near 800 Hz). The gain legs lift the treble more than the bass, and CFB with RV1 rolls the gain off above about 16 kHz.
* Clip: CC 4.7u and RC 1k from the op-amp output, then two 1N914 to ground. They clip at about +-0.7 V, hard and buzzy. The slow LM308 (30 pF) rounds the edges.
* Filter: RF 1.5k in series with RV2 (100k linear Filter, as a variable resistor) into CF 3.3n to ground, a low-pass with its corner from 32 kHz (Filter at 0) to 475 Hz (Filter at 1). At 5 kHz, Filter at 1 is 20.3 dB below Filter at 0 (simulated).
* Output: CB 22n and RBB 1M into the buffer, then RV3 (100k log Volume). The buffer is a 2N5458 JFET source follower, as in the published RAT: the gate is at the CB/RBB node, the drain is at VCC, RE 10k runs from the source to VEE, and the Volume pot hangs on the source. The published RAT is on a single 9 V supply with the source at 0 V; on the +-4.5 V rails here RS goes to VEE, and the simulated bias is Vgs about -2.6 V, Vds about 1.9 V and Id about 0.7 mA, so the follower stays in saturation for the +-0.7 V signal. The 2N5458 model is mid-range of a wide datasheet spread (see models/jfet-2n5458.lib), so a real part moves the bias point.
* Supply: the 9 V rail is modelled as VCC = +4.5 V and VEE = -4.5 V around signal ground, because the LM308 model finds no operating point on 0 V to 9 V.
* ssp:input in
* ssp:output out
* ssp:knob RV1 log 0.5
* ssp:knob RV2 linear 0.5
* ssp:knob RV3 log 0.5
* provenance: LM108/LM208/LM308 operational amplifiers datasheet TL/H/7758, National Semiconductor, December 1994 (read from a third-party mirror; no current TI copy was reachable); gain, swing and input resistance read from the datasheet. GBW and slew rate are UNVERIFIED: the datasheet text states no value, and they are taken from the 30 pF compensation case (the 30 pF itself is inside the model: the .subckt has no pin 1 to pin 8)
* fit: open-loop gain 300 V/mV, output swing +-14 V at RL = 10 kOhm (1 V rail drop), input resistance 40 MOhm (all p2); GBW 1 MHz and slew rate 0.3 V/us with 30 pF are UNVERIFIED; output resistance 100 Ohm is a typical value, not a sheet figure
* provenance: 1N4148 small signal fast switching diode datasheet, document 81857, Rev. 1.6 (07-Nov-2024), Vishay Semiconductors, https://www.vishay.com/docs/81857/1n4148.pdf; the sheet states the 1N914 is electrically equivalent, so the RAT's 1N914 uses this model
* fit: IS = 6.5e-9 and N = 1.9 put VF at 0.70 V at IF = 10 mA; CJO = 4 pF is the sheet maximum at VR = 0 V
* provenance: 2N5457, 2N5458, 2N5459 JFET datasheet 2N5457/D, onsemi (Fairchild), https://www.onsemi.com/download/data-sheet/pdf/2n5457-d.pdf; read from memory of the table, not re-checked against the PDF, so UNVERIFIED
* fit: mid-range of the 2N5458 spread: IDSS 5.5 mA (sheet 2 to 9 mA), VGS(off) -4 V (sheet -1 to -7 V), Beta 0.344 mA/V^2 derived as IDSS / Vto^2; CGD = 1.5p (Crss max), CGS = 3p (Ciss 4.5 pF less CGD, derived)
* author: 4esv
* license: MIT

* Pins: inp inn out vcc vee. Gain 300000 V/V, GBW 1E+06 Hz, slew rate 300000 V/s, rail drop 1 V.
.subckt LM308 inp inn out vcc vee
Rid inp inn 4E+07
Bgm 0 x I={0.000143239*tanh(0.003*V(inp,inn)/0.000143239)}
Rp x 0 1E+08
Cc x 0 4.77465E-10
Bclamp x 0 I={7.16197E-05*(sqrt((V(x)-V(vcc))*(V(x)-V(vcc))+0.000001)-sqrt((V(x)-V(vee))*(V(x)-V(vee))+0.000001)+V(x)-V(vcc)+V(x)-V(vee))}
Bo o 0 V={V(x)}
Rout o out 100
Blo lo 0 V={V(vee)+1-0.5*(V(vee)-V(vcc)+2+sqrt((V(vee)-V(vcc)+2)*(V(vee)-V(vcc)+2)+0.000001))}
Bout out 0 I={50*(sqrt((V(out)-V(vcc)+1)*(V(out)-V(vcc)+1)+0.000001)-sqrt((V(out)-V(lo))*(V(out)-V(lo))+0.000001)+V(out)-V(vcc)+1+V(out)-V(lo))}
.ends LM308

.model 1N4148 D(IS=6.5e-9 N=1.9 CJO=4p)
.model J2N5458 NJF(Beta=3.44e-4 Vto=-4 CGS=3p CGD=1.5p)

V1 in 0 DC 0 AC 1
VCC vcc 0 DC 4.5
VEE vee 0 DC -4.5
CIN in a1 22n
RB a1 0 2.2Meg
RIN a1 a 1k
CRF a 0 1n
X1 a fb o vcc vee LM308
RV1_1 nc o 50k
RV1_2 o fb 50k
CFB o fb 100p
RG1 fb g1 560
CG1 g1 0 4.7u
RG2 fb g2 47
CG2 g2 0 2.2u
CC o k 4.7u
RC k d 1k
D1 d 0 1N4148
D2 0 d 1N4148
RF d f1 1.5k
RV2_1 nf f 50k
RV2_2 f f1 50k
CF f 0 3.3n
CB f b 22n
RBB b 0 1Meg
J1 vcc b e J2N5458
RE e vee 10k
RV3_1 e v 50k
RV3_2 v 0 50k
COUT v out 1u
RL out 0 100k
.END
