* ssp:title Op-amp hard-clip distortion (RAT)
* Values: the ProCo RAT schematic as commonly published, and the public circuit analysis at electrosmash.com/proco-rat. The LM308 sits in a non-inverting stage; RV1 (100k Distortion, wiper = output, one end open) is the feedback, two gain legs (560 + 4.7u, 47 + 2.2u) from the inverting input to ground set Rg.
* Sound: gain 1 + RV1 / Rg reaches about 64 dB at 1 kHz, and the gain legs lift the treble more than the bass. The slow LM308 (30 pF) rounds the edges. Two 1N914 to ground clip at about +-0.7 V, hard and buzzy.
* RV2 (100k Filter) with 3.3n is a low-pass after the clippers (482 Hz corner at 1). A 2N5088 emitter follower buffers it; RV3 (100k Volume) sets the level.
* Supply: the 9 V rail is modelled as VCC = +4.5 V and VEE = -4.5 V around signal ground, because the LM308 model finds no operating point on 0 V to 9 V.
* ssp:input in
* ssp:output out
* ssp:knob RV1 linear 0.5
* ssp:knob RV2 linear 0.5
* ssp:knob RV3 linear 0.5
* provenance: LM108/LM208/LM308 operational amplifiers datasheet TL/H/7758, National Semiconductor, December 1994 (read from a third-party mirror; no current TI copy was reachable); gain, swing and input resistance read from the datasheet. GBW and slew rate are UNVERIFIED: the datasheet text states no value, and they are taken from the 30 pF compensation case (the 30 pF itself is inside the model: the .subckt has no pin 1 to pin 8)
* fit: open-loop gain 300 V/mV, output swing +-14 V at RL = 10 kOhm (1 V rail drop), input resistance 40 MOhm (all p2); GBW 1 MHz and slew rate 0.3 V/us with 30 pF are UNVERIFIED; output resistance 100 Ohm is a typical value, not a sheet figure
* provenance: 1N4148 small signal fast switching diode datasheet, document 81857, Rev. 1.6 (07-Nov-2024), Vishay Semiconductors, https://www.vishay.com/docs/81857/1n4148.pdf; the sheet states the 1N914 is electrically equivalent, so the RAT's 1N914 uses this model
* fit: IS = 6.5e-9 and N = 1.9 put VF at 0.70 V at IF = 10 mA; CJO = 4 pF is the sheet maximum at VR = 0 V
* provenance: 2N5088 NPN general-purpose amplifier datasheet 2N5088-D, onsemi, https://www.onsemi.com/download/data-sheet/pdf/2n5088-d.pdf
* fit: hFE 500 and VBE 0.601 V at IC = 1 mA, VCE = 5 V; CJC = 4p and CJE = 10p are the sheet maxima
* author: 4esv
* license: MIT

* Pins: inp inn out vcc vee. Gain 300000 V/V, GBW 1E+06 Hz, slew rate 300000 V/s, rail drop 1 V.
.subckt LM308 inp inn out vcc vee
Rid inp inn 4E+07
Bgm 0 x I={0.000143239*tanh(0.003*V(inp,inn)/0.000143239)}
Rp x 0 1E+08
Cc x 0 4.77465E-10
Bclamp x 0 I={7.16197E-05*(sqrt((V(x)-V(vcc))*(V(x)-V(vcc))+0.000001)-sqrt((V(x)-V(vee))*(V(x)-V(vee))+0.000001)+V(x)-V(vcc)+V(x)-V(vee))}
Bo o 0 V={V(x)}
Rout o out 100
Blo lo 0 V={V(vee)+1-0.5*(V(vee)-V(vcc)+2+sqrt((V(vee)-V(vcc)+2)*(V(vee)-V(vcc)+2)+0.000001))}
Bout out 0 I={50*(sqrt((V(out)-V(vcc)+1)*(V(out)-V(vcc)+1)+0.000001)-sqrt((V(out)-V(lo))*(V(out)-V(lo))+0.000001)+V(out)-V(vcc)+1+V(out)-V(lo))}
.ends LM308

.model 1N4148 D(IS=6.5e-9 N=1.9 CJO=4p)
.model Q2N5088 NPN (IS=8e-14 BF=500 CJC=4p CJE=10p)

V1 in 0 DC 0 AC 1
VCC vcc 0 DC 4.5
VEE vee 0 DC -4.5
CIN in a 22n
RB a 0 1Meg
X1 a fb o vcc vee LM308
RV1_1 nc o 50k
RV1_2 o fb 50k
RG1 fb g1 560
CG1 g1 0 4.7u
RG2 fb g2 47
CG2 g2 0 2.2u
D1 o 0 1N4148
D2 0 o 1N4148
RV2_1 c w 50k
RV2_2 w o 50k
CF c 0 3.3n
Q1 vcc w e Q2N5088
RE e vee 2.2k
RV3_1 e v 50k
RV3_2 v 0 50k
COUT v out 1u
RL out 0 100k
.END
