* ssp:title Transistor fuzz
* source: original design in this repo, drawn in the editor on 2026-10-04
* Common-emitter NPN stage with a diode pair that clips the signal in both directions.
* Try: the pot RV1 is the volume. The value of R6 (base bias to the 9 V rail) sets the bias: a lower value gives a harder, gatier fuzz.
* author: 4esv
* license: MIT
* schematic
* ssp:input in
V1 in 0 DC 0 AC 1 SINE(0 0.05 220)
C1 in n4 100n
.model QNPN NPN (IS=1e-14 BF=200)
Q1 n3 n4 n6 0 QNPN
R2 n3 n10 2.2k
V2 n10 0 DC 9
C2 n3 n8 100n
.model DGEN D (IS=1e-14 N=1.9)
D1 n8 0 DGEN
D2 0 n8 DGEN
RV1_1 n8 n9 5k
RV1_2 n9 0 5k
* ssp:knob RV1 linear 0.5
* ssp:output n9
R4 n6 0 1k
C3 n6 0 22u
R5 n4 0 47k
R6 n4 n10 100k
