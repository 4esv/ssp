* ssp:title Low-pass and high-pass blend tone control
* Low-pass: 1 / (2 pi * R1 * C1) = 1 / (2 pi * 22k * 10n) = 723 Hz.
* High-pass: 1 / (2 pi * R2 * C2) = 1 / (2 pi * 100k * 1n) = 1.59 kHz.
* RV1 blends the two. At the middle of the knob the gap between the corners gives a mid-range scoop.
* Knob at 1: high-pass only (bright). Knob at 0: low-pass only (dark).
* ssp:input in
* ssp:output out
* ssp:knob RV1 linear 0.5
V1 in 0 DC 0 AC 1
R1 in lp 22k
C1 lp 0 10n
C2 in hp 1n
R2 hp 0 100k
RV1_1 hp out 50k
RV1_2 out lp 50k
RL out 0 1Meg
.END
