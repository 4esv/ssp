* ssp:title Non-inverting gain stage, TL072
* Gain: 1 + RF / RG = 1 + 100k / 10k = 11 (20.8 dB).
* Input high-pass: 1 / (2 pi * RB * CIN) = 1 / (2 pi * 1M * 100n) = 1.6 Hz. Input impedance is about RB = 1 MOhm.
* Gain-leg high-pass: 1 / (2 pi * RG * CG) = 1 / (2 pi * 10k * 10u) = 1.6 Hz.
* Feedback low-pass: 1 / (2 pi * RF * CF) = 1 / (2 pi * 100k * 100p) = 15.9 kHz.
* Supply: the 9 V rail is modelled as VCC = +4.5 V and VEE = -4.5 V around signal ground. Ground stands for the 4.5 V reference
*   of power-9v.cir. The op-amp models in models/ do not find a DC operating point on a 0 V to 9 V single supply.
* ssp:input in
* ssp:output out
* provenance: TL07xx low-noise JFET-input operational amplifiers datasheet SLOS080W (revised July 2025), Texas Instruments, https://www.ti.com/lit/ds/symlink/tl072.pdf; values read from the datasheet, typical column, VS = +-15 V, TA = 25 C
* fit: open-loop gain 200 V/mV (p15), GBW 5.25 MHz for D and P packages (3 MHz for NS and PS packages) (p15), slew rate 20 V/us at RL = 2 kOhm, CL = 100 pF (p16), output swing +-13.5 V at RL = 10 kOhm (1.5 V rail drop) (p15), input resistance 1e12 Ohm (p15); output resistance 200 Ohm is a typical value, not a sheet figure
* author: 4esv
* license: MIT

* Pins: inp inn out vcc vee. Gain 200000 V/V, GBW 5.25E+06 Hz, slew rate 2E+07 V/s, rail drop 1.5 V.
.subckt TL072 inp inn out vcc vee
Rid inp inn 1E+12
Bgm 0 x I={0.00121261*tanh(0.002*V(inp,inn)/0.00121261)}
Rp x 0 1E+08
Cc x 0 6.06305E-11
Bclamp x 0 I={0.000606305*(sqrt((V(x)-V(vcc))*(V(x)-V(vcc))+0.000001)-sqrt((V(x)-V(vee))*(V(x)-V(vee))+0.000001)+V(x)-V(vcc)+V(x)-V(vee))}
Bo o 0 V={V(x)}
Rout o out 200
Blo lo 0 V={V(vee)+1.5-0.5*(V(vee)-V(vcc)+3+sqrt((V(vee)-V(vcc)+3)*(V(vee)-V(vcc)+3)+0.000001))}
Bout out 0 I={50*(sqrt((V(out)-V(vcc)+1.5)*(V(out)-V(vcc)+1.5)+0.000001)-sqrt((V(out)-V(lo))*(V(out)-V(lo))+0.000001)+V(out)-V(vcc)+1.5+V(out)-V(lo))}
.ends TL072

V1 in 0 DC 0 AC 1
VCC vcc 0 DC 4.5
VEE vee 0 DC -4.5
CIN in a 100n
RB a 0 1Meg
X1 a fb o vcc vee TL072
RF o fb 100k
CF o fb 100p
RG fb g 10k
CG g 0 10u
COUT o out 10u
RL out 0 100k
.END
