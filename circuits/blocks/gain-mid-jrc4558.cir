* ssp:title Mid-focused gain stage, JRC4558
* The gain leg RG + CG passes only frequencies above 1 / (2 pi * 3.3k * 68n) = 709 Hz.
*   Below that corner the gain falls to 1. Above it the gain is 1 + 220k / 3.3k = 67.7 (36.6 dB).
* CF limits the top end: 1 / (2 pi * 220k * 100p) = 7.2 kHz. The result is a mid-range hump.
*   The corners overlap, so the simulated peak is 35.8 dB near 2.2 kHz.
* Input high-pass: 1 / (2 pi * 1M * 47n) = 3.4 Hz.
* Supply: the 9 V rail is modelled as VCC = +4.5 V and VEE = -4.5 V around signal ground. Ground stands for the 4.5 V reference
*   of power-9v.cir. The op-amp models in models/ do not find a DC operating point on a 0 V to 9 V single supply.
* ssp:input in
* ssp:output out
* provenance: NJM4558 dual operational amplifier datasheet Ver. 20260723, Nisshinbo Micro Devices (JRC), https://www.nisshinbo-microdevices.co.jp/en/pdf/datasheet/NJM4558_E.pdf; values read from the datasheet, typical column, V+/V- = +-15 V, Ta = 25 C
* fit: open-loop gain 100 dB (100 V/mV), GBW 3 MHz, slew rate 1 V/us, output swing +-14 V at RL >= 10 kOhm (1 V rail drop), input resistance 5 MOhm (all p2); output resistance 75 Ohm is a typical value, not a sheet figure
* author: 4esv
* license: MIT

* Pins: inp inn out vcc vee. Gain 100000 V/V, GBW 3E+06 Hz, slew rate 1E+06 V/s, rail drop 1 V.
.subckt JRC4558 inp inn out vcc vee
Rid inp inn 5E+06
Bgm 0 x I={5.30516E-05*tanh(0.001*V(inp,inn)/5.30516E-05)}
Rp x 0 1E+08
Cc x 0 5.30516E-11
Bclamp x 0 I={5.30516E-05*(V(x)-(0.5*((0.5*(V(x)+V(vee)+sqrt((V(x)-(V(vee)))*(V(x)-(V(vee)))+0.000001)))+V(vcc)-sqrt(((0.5*(V(x)+V(vee)+sqrt((V(x)-(V(vee)))*(V(x)-(V(vee)))+0.000001)))-(V(vcc)))*((0.5*(V(x)+V(vee)+sqrt((V(x)-(V(vee)))*(V(x)-(V(vee)))+0.000001)))-(V(vcc)))+0.000001))))}
Bo o 0 V={V(x)}
Rout o out 75
Bout out 0 I={100*(V(out)-(0.5*((0.5*(V(out)+V(vee)+1+sqrt((V(out)-(V(vee)+1))*(V(out)-(V(vee)+1))+0.000001)))+V(vcc)-1-sqrt(((0.5*(V(out)+V(vee)+1+sqrt((V(out)-(V(vee)+1))*(V(out)-(V(vee)+1))+0.000001)))-(V(vcc)-1))*((0.5*(V(out)+V(vee)+1+sqrt((V(out)-(V(vee)+1))*(V(out)-(V(vee)+1))+0.000001)))-(V(vcc)-1))+0.000001))))}
.ends JRC4558

V1 in 0 DC 0 AC 1
VCC vcc 0 DC 4.5
VEE vee 0 DC -4.5
CIN in a 47n
RB a 0 1Meg
X1 a fb o vcc vee JRC4558
RF o fb 220k
CF o fb 100p
RG fb g 3.3k
CG g 0 68n
COUT o out 10u
RL out 0 100k
.END
