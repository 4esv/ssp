* ssp:title Active Baxandall bass and treble, TL072
* The op-amp is an inverting stage. Its input and feedback networks are mirror images, so at mid knob the gain is -1 (0 dB).
* Bass: R1 = R2 = 10k with RV1 = 100k gives up to about +-20 dB. C1 and C2 (22n) bypass RV1 above about 1 / (2 pi * 50k * 22n) = 145 Hz.
* Treble: CT1 = CT2 = 2.2n with RV2 = 100k. The treble shelf starts near 1 / (2 pi * 10k * 2.2n) = 7.2 kHz.
* Supply: the 9 V rail is modelled as VCC = +4.5 V and VEE = -4.5 V around signal ground. Ground stands for the 4.5 V reference
*   of power-9v.cir. The op-amp models in models/ do not find a DC operating point on a 0 V to 9 V single supply.
* ssp:input in
* ssp:output out
* ssp:knob RV1 linear 0.5
* ssp:knob RV2 linear 0.5
* provenance: TL07xx low-noise JFET-input operational amplifiers datasheet SLOS080W (revised July 2025), Texas Instruments, https://www.ti.com/lit/ds/symlink/tl072.pdf; values read from the datasheet, typical column, VS = +-15 V, TA = 25 C
* fit: open-loop gain 200 V/mV (p15), GBW 5.25 MHz for D and P packages (3 MHz for NS and PS packages) (p15), slew rate 20 V/us at RL = 2 kOhm, CL = 100 pF (p16), output swing +-13.5 V at RL = 10 kOhm (1.5 V rail drop) (p15), input resistance 1e12 Ohm (p15); output resistance 200 Ohm is a typical value, not a sheet figure
* author: 4esv
* license: MIT

* Pins: inp inn out vcc vee. Gain 200000 V/V, GBW 5.25E+06 Hz, slew rate 2E+07 V/s, rail drop 1.5 V.
.subckt TL072 inp inn out vcc vee
Rid inp inn 1E+12
Bgm 0 x I={0.00121261*tanh(0.002*V(inp,inn)/0.00121261)}
Rp x 0 1E+08
Cc x 0 6.06305E-11
Bclamp x 0 I={0.00121261*(V(x)-(0.5*((0.5*(V(x)+V(vee)+sqrt((V(x)-(V(vee)))*(V(x)-(V(vee)))+0.000001)))+V(vcc)-sqrt(((0.5*(V(x)+V(vee)+sqrt((V(x)-(V(vee)))*(V(x)-(V(vee)))+0.000001)))-(V(vcc)))*((0.5*(V(x)+V(vee)+sqrt((V(x)-(V(vee)))*(V(x)-(V(vee)))+0.000001)))-(V(vcc)))+0.000001))))}
Bo o 0 V={V(x)}
Rout o out 200
Bout out 0 I={100*(V(out)-(0.5*((0.5*(V(out)+V(vee)+1.5+sqrt((V(out)-(V(vee)+1.5))*(V(out)-(V(vee)+1.5))+0.000001)))+V(vcc)-1.5-sqrt(((0.5*(V(out)+V(vee)+1.5+sqrt((V(out)-(V(vee)+1.5))*(V(out)-(V(vee)+1.5))+0.000001)))-(V(vcc)-1.5))*((0.5*(V(out)+V(vee)+1.5+sqrt((V(out)-(V(vee)+1.5))*(V(out)-(V(vee)+1.5))+0.000001)))-(V(vcc)-1.5))+0.000001))))}
.ends TL072

V1 in 0 DC 0 AC 1
VCC vcc 0 DC 4.5
VEE vee 0 DC -4.5
X1 0 n o vcc vee TL072
CIN in a 1u
R1 a b1 10k
RV1_1 b1 w1 50k
RV1_2 w1 b2 50k
R2 b2 o 10k
C1 b1 w1 22n
C2 w1 b2 22n
R3 w1 n 10k
CT1 a t1 2.2n
RV2_1 t1 n 50k
RV2_2 n t2 50k
CT2 t2 o 2.2n
COUT o out 10u
RL out 0 100k
.END
