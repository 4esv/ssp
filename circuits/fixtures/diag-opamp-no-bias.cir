* ssp:title Op-amp input with no bias
* C1 blocks DC, so the positive input of X1 has no DC path to ground.
* A test adds the TL072 model from models/opamp-tl072.cir.
* ssp:input in
* ssp:output out
V1 in 0 DC 0 AC 1
Vcc vcc 0 DC 9
C1 in nobias 1u
X1 nobias out out vcc 0 TL072
Rl out 0 10k
.END
