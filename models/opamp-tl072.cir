* provenance: TL07xx low-noise JFET-input operational amplifiers datasheet, Texas Instruments, https://www.ti.com/product/TL072; values typed from memory of the sheet and UNVERIFIED against the current revision
* fit: typical at +-15 V: open-loop gain 200 V/mV, GBW 3 MHz, slew rate 13 V/us, output swing +-13.5 V at RL = 10 kOhm (1.5 V rail drop), input resistance 1e12 Ohm; output resistance 200 Ohm is a typical value, not a sheet figure
* author: 4esv
* license: MIT

* Pins: inp inn out vcc vee. Gain 200000 V/V, GBW 3E+06 Hz, slew rate 1.3E+07 V/s, rail drop 1.5 V.
.subckt TL072 inp inn out vcc vee
Rid inp inn 1E+12
Bgm 0 x I={0.00137934*tanh(0.002*V(inp,inn)/0.00137934)}
Rp x 0 1E+08
Cc x 0 1.06103E-10
Bclamp x 0 I={0.00137934*(V(x)-(0.5*((0.5*(V(x)+V(vee)+sqrt((V(x)-(V(vee)))*(V(x)-(V(vee)))+0.000001)))+V(vcc)-sqrt(((0.5*(V(x)+V(vee)+sqrt((V(x)-(V(vee)))*(V(x)-(V(vee)))+0.000001)))-(V(vcc)))*((0.5*(V(x)+V(vee)+sqrt((V(x)-(V(vee)))*(V(x)-(V(vee)))+0.000001)))-(V(vcc)))+0.000001))))}
Bo o 0 V={V(x)}
Rout o out 200
Bout out 0 I={100*(V(out)-(0.5*((0.5*(V(out)+V(vee)+1.5+sqrt((V(out)-(V(vee)+1.5))*(V(out)-(V(vee)+1.5))+0.000001)))+V(vcc)-1.5-sqrt(((0.5*(V(out)+V(vee)+1.5+sqrt((V(out)-(V(vee)+1.5))*(V(out)-(V(vee)+1.5))+0.000001)))-(V(vcc)-1.5))*((0.5*(V(out)+V(vee)+1.5+sqrt((V(out)-(V(vee)+1.5))*(V(out)-(V(vee)+1.5))+0.000001)))-(V(vcc)-1.5))+0.000001))))}
.ends TL072
