* provenance: LM108/LM208/LM308 operational amplifiers datasheet TL/H/7758, National Semiconductor, December 1994 (read from a third-party mirror; no current TI copy was reachable); gain, swing and input resistance read from the datasheet. GBW and slew rate are UNVERIFIED: the datasheet text states no value, and they are taken from the 30 pF compensation case
* fit: open-loop gain 300 V/mV, output swing +-14 V at RL = 10 kOhm (1 V rail drop), input resistance 40 MOhm (all p2); GBW 1 MHz and slew rate 0.3 V/us with 30 pF are UNVERIFIED; output resistance 100 Ohm is a typical value, not a sheet figure
* author: 4esv
* license: MIT

* Pins: inp inn out vcc vee. Gain 300000 V/V, GBW 1E+06 Hz, slew rate 300000 V/s, rail drop 1 V.
.subckt LM308 inp inn out vcc vee
Rid inp inn 4E+07
Bgm 0 x I={0.000143239*tanh(0.003*V(inp,inn)/0.000143239)}
Rp x 0 1E+08
Cc x 0 4.77465E-10
Bclamp x 0 I={7.16197E-05*(sqrt((V(x)-V(vcc))*(V(x)-V(vcc))+0.000001)-sqrt((V(x)-V(vee))*(V(x)-V(vee))+0.000001)+V(x)-V(vcc)+V(x)-V(vee))}
Bo o 0 V={V(x)}
Rout o out 100
Blo lo 0 V={V(vee)+1-0.5*(V(vee)-V(vcc)+2+sqrt((V(vee)-V(vcc)+2)*(V(vee)-V(vcc)+2)+0.000001))}
Bout out 0 I={50*(sqrt((V(out)-V(vcc)+1)*(V(out)-V(vcc)+1)+0.000001)-sqrt((V(out)-V(lo))*(V(out)-V(lo))+0.000001)+V(out)-V(vcc)+1+V(out)-V(lo))}
.ends LM308
